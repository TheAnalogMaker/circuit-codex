* 5F8-A (High-power Tweed Twin-style) — DC operating-point netlist
* Circuit Codex — CC-BY-SA 4.0. Independently drawn from the published 5F8-A
* (I-EG) drawing's component values (see meta.yaml); no drawing reproduced.
*
* DC conventions: B+1 driven at the printed +397 V; downstream nodes DERIVED.
* The GZ34 and the standby switch ahead of B+1 are therefore not in this deck.
* Choke (14684) modeled as a 130R DCR estimate — the drawing prints 397 -> 395
* across it, the same 2 V the 5F6-A's sheet prints across the same part number.
* OT primary DCR omitted (both plate nodes and the centre tap collapse to B+1).
* The bias supply is replaced by an ideal -41 V source (its selenium rectifier,
* 15k/56k and two 8uF/150V cans are rectification and ripple filtering).
* DC-open caps are MODELLED where both leads land on a named DC node (the
* PI->output couplers C8/C9, the V3B grid's AC ground C7 and the shared 12AY7
* cathode bypass C3) so their board placement is layout-checked; open at DC,
* they move no operating point. Caps into the abstracted volume/tone network,
* and the presence pot's wiper cap C16, stay omitted.
*
* TUBE MODEL MAPPING: the drawing letters four 5881s and models/5881.inc is the
* corpus's own 5881 fit, so no substitution is made anywhere in this deck. The
* 12AY7, 12AX7 and GZ34 the sheet letters likewise each have their own model.
.include models/12ay7.inc
.include models/12ax7.inc
.include models/5881.inc

VBP1 BP1 0 DC 397
VBIAS NBIAS 0 DC -41

* rail: choke -> screens node, 4700R -> PI node, 10k -> preamp node
RCHOKE BP1 BP2 130
RD1 BP2 BP3 4.7k
RD2 BP3 BP4 10k

* V1 12AY7 — bright + normal channels, shared 820R cathode (250uF bypass)
RL1 BP4 PAY1 100k
XV1A PAY1 GAY1 KAY 12AY7
RG1 GAY1 0 1meg
RL2 BP4 PAY2 100k
XV1B PAY2 GAY2 KAY 12AY7
RG2 GAY2 0 1meg
RK1 KAY 0 820

* V2A 12AX7 second stage (grid returns through the vol pots + 270k mixers at
* DC), 820R cathode, unbypassed as the sheet draws it
RL3 BP4 P2A 100k
XV2A P2A G2A K2A 12AX7
RG3 G2A 0 1meg
RK2 K2A 0 820

* V2B cathode follower — grid DC-coupled to V2A plate, 100k cathode load
XV2B BP4 P2A KCF 12AX7
RKCF KCF 0 100k

* Long-tailed-pair phase inverter (82k/100k 5% plates, 470R + 10k tail, both 1M
* grid leaks to the tail junction J, 47 pF across the plates; the 10k's foot is
* its own node).
RLA BP3 PPIA 82k
XV3A PPIA GPIA KPI 12AX7
RGA GPIA JPI 1meg
RLB BP3 PPIB 100k
XV3B PPIB GPIB KPI 12AX7
RGB GPIB JPI 1meg
RTAIL KPI JPI 470
RT2 JPI PRES 10k
* The tail's foot, as the I-EG schematic and layout both wire it: the 10k does
* not return to ground but to a node of its own, PRES, which carries the 56k
* negative-feedback resistor from the speaker (the OT secondary is DC ground, so
* its far end is node 0), the top of the 5k presence pot's track (lower lug to
* ground; its 0.1 uF wiper cap C16 is open at DC and omitted) and the V3B grid's
* 0.1 uF AC ground C7. The 56k and the 5k track are both DC returns, so the foot
* sits at the tail current times their 4.6k parallel resistance. The printed
* tail figures do not fit this topology: see the KPI/JPI notes in voltages.yaml.
RNF PRES 0 56k
RPRES PRES 0 5k
C7 GPIB PRES 0.1u
* 47 pF across the two PI plates — DC-open, but both leads land on named DC
* nodes, so it is modelled and its placement is drawing- and layout-checked.
C10 PPIA PPIB 47p

* Four 5881s in two parallel pairs — V4+V5 on the 82k side, V6+V7 on the 100k
* side. Each pair takes ONE 0.1u coupler and ONE 220k leak from the -41 V line;
* the 1500R grid stopper sits BETWEEN the pair's two grids (on the board it
* bridges socket to socket), so the coupler node is the first grid and the
* second grid sits behind the stopper. Cathodes are grounded; 470R 1W screen
* resistors off the +395 V screens node.
* NOTE: these MUST be four distinct bottle instances (XV4..XV7). Naming any of
* them XVnA / XVnB would collapse them into one dual-section bottle (the netlist
* parser reads a trailing A/B as a triode-half section), which is wrong for four
* single-ended power pentodes and mis-anchors the layout-equivalence check.
RGL1 NBIAS GA1 220k
XV4 BP1 SA1 GA1 0 5881
RS1 BP2 SA1 470
RGS1 GA1 GA2 1.5k
XV5 BP1 SA2 GA2 0 5881
RS2 BP2 SA2 470
RGL2 NBIAS GB1 220k
XV6 BP1 SB1 GB1 0 5881
RS3 BP2 SB1 470
RGS2 GB1 GB2 1.5k
XV7 BP1 SB2 GB2 0 5881
RS4 BP2 SB2 470
* PI-plate -> output-grid coupling caps (0.1u, DC-open). Modelled so the layout-
* equivalence gate checks the inter-stage routing and push-pull phase natively:
* C8 carries V3A (82k plate) to the V4/V5 pair, C9 carries V3B (100k plate) to
* the V6/V7 pair. At DC each grid still sits at the -41 V bias node through its
* 220k leak (no grid current), so these add no DC loading and the op point is
* unmoved.
C8 PPIA GA1 0.1u
C9 PPIB GB1 0.1u

* cathode-bypass cap (both leads on a named DC node — placement layout-checked)
C3 KAY 0 250u
