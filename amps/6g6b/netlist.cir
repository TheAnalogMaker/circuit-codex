* 6G6-B (Blonde Bassman-style) — DC operating-point netlist
* Circuit Codex — CC-BY-SA 4.0. Independently drawn from the published 6G6-B
* (E-FB) drawing's component values (see meta.yaml); no drawing reproduced.
* The drawing labels all four preamp bottles 7025 — an alias for the 12AX7
* (reference/tubes/12ax7.yaml also_known_as) — so every small-signal stage
* uses the clean-room 12AX7 model.
*
* DC conventions — RAILS. The E-FB drawing prints a figure at every node of
* its supply chain, and hangs a 20 uF/600 V filter on each one: +430 V at
* the rectifier's reservoir (two of those cans in parallel) and +430 V again
* on the far side of the standby switch, where the choke (TR2) takes it and
* a lead carries it up to the OUTPUT TRANSFORMER'S PRIMARY CENTRE TAP;
* +428 V at node B, the choke's far end, which feeds the two 470 Ohm screen
* stoppers and the whole dropper chain; +410 V on the phase inverter's plate
* lane; +355 V at node C (the Normal row's lane); and +230 V under the Bass
* row. The standby switch is omitted here, so the reservoir and the OT
* centre tap are one node, BP430. Only the two ends of the choke are driven,
* as ideal sources at their printed values — BP430 (reservoir and OT centre
* tap: the 5881 plates, primary DCR omitted) and BP428 (node B: the 5881
* screens and the droppers) — because the choke's DCR and the rectifier's
* source impedance are not on the drawing. The other three rails are
* DERIVED through the drawn droppers, in the drawing's own order:
*   node B (+428) -> 4.7k 1W (RD1) -> BP410 (the phase inverter's two plate
*   loads) -> 27k 1W (RD2) -> node C, BP355 (BOTH Normal-channel plate
*   loads); and node B -> 56k 1W (RD3) -> BP230 (the Bass row's lane: V1A's
*   plate load, V1B's plate direct, and both V3 plate loads).
* Each derived rail is gated against its printed figure (voltages.yaml).
*
* The +230 V figure is a RAIL here and a PLATE VOLTAGE in the Normal channel:
* the drawing letters "+230 V." twice on the Bass row's own supply lane, and
* once more on the Normal channel at V2A's plate node — whose 100k load
* climbs to the +355 V lane, not to any +230 V rail. Reading that third
* "+230 V." as a shared preamp rail is what made an earlier pass hang V2A's
* plate load on +230 V and miss the printed cathode by a third.
*
* Two full channels (Bass, Normal) mix only at the phase inverter's input:
* the Bass channel runs on through V3 (V3A off its Volume wiper, its own
* Treble control, V3B), and V3B's plate and the Normal channel's V2B plate
* each feed a 470k into one mixing node (MIX), which a .0005 uF cap couples
* into the long-tailed-pair phase inverter ahead of a fixed-bias 5881 pair.
* Each channel's Bass/Treble/Volume network is an abstracted control island
* (NOT modelled — same convention as every other amp in the corpus), as is
* the Bass channel's own Treble control between V3's two sections.
* Grid-leak resistors below stand in for "returns to ~0 V DC through the
* volume pot above it" — since these stages draw no grid current, the exact
* leak value does not move the tube's own operating point (set by its
* cathode resistor and rail).
.include models/12ax7.inc
.include models/5881.inc

VBP428 BP428 0 DC 428
VBP430 BP430 0 DC 430
RD1 BP428 BP410 4.7k
RD2 BP410 BP355 27k
RD3 BP428 BP230 56k
VBIAS  NBIAS 0 DC -54

* --- V1 (7025 = 12AX7) — BASS channel
* V1A input: 220k plate load off the Bass row's +230 V lane, 2700 Ohm
* cathode (bypassed on the drawing; DC-irrelevant). Grid returns to ground
* through the two 68 kOhm jack stoppers' 1 MOhm leak (jack parts, BOM only).
RL1A BP230 P1A 220k
XV1A P1A G1A K1A 12AX7
RG1A G1A 0 1meg
RK1A K1A 0 2700

* V1B — CATHODE FOLLOWER, exactly as the sheet draws it: the plate lead runs
* straight down to the +230 V lane with NO plate-load resistor in it, the
* grid takes V1A's plate DIRECTLY (no coupling cap, no grid leak drawn), and
* the 100 kOhm cathode load to ground is the stage's output, feeding the Bass
* channel's Bass/Volume network. The chart's +136 V here is that cathode:
* a follower riding ~1 V above the +135 V plate it is tied to, passing
* 1.36 mA through the 100 kOhm. (An earlier pass read the label as "+13.6 V"
* — the mark between the 3 and the 6 is the +230 V lane's own wire crossing
* the lettering — and modelled a common-cathode stage with an invented
* coupling cap, grid leak and 220k plate load. None of those three parts is
* on the sheet.)
XV1B BP230 P1A K1B 12AX7
RK1B K1B 0 100k

* --- V2 (7025) — NORMAL channel
* V2A input: 1500 Ohm cathode, 100k plate load climbing to the +355 V lane;
* its plate node is the chart's third "+230 V." reading, and the 125 V across
* that 100k is the 1.25 mA the printed 1.9 V over 1500 Ohm also implies.
RL2A BP355 P2A 100k
XV2A P2A G2A K2A 12AX7
RG2A G2A 0 1meg
RK2A K2A 0 1500

* V2B recovery: 2700 Ohm cathode, 220k plate load off the same +355 V lane.
RL2B BP355 P2B 220k
XV2B P2B G2B K2B 12AX7
RG2B G2B 0 1meg
RK2B K2B 0 2700

* --- V3 (7025) — the Bass channel's later stages. V3A takes the Bass
* Volume's wiper (network not modelled, see header); the Bass channel's own
* Treble control (250k-A) sits between V3A's plate and V3B's grid. Both
* sections read +150 V on the chart off their own 100k/+230 V legs, and both
* cathodes are chart-read: 1500 Ohm at +1.2 V (V3A, bypassed) and 1500 Ohm
* at +1.3 V (V3B).
RL3A BP230 P3A 100k
XV3A P3A G3A K3A 12AX7
RG3A G3A 0 1meg
RK3A K3A 0 1500

RL3B BP230 P3B 100k
XV3B P3B G3B K3B 12AX7
RG3B G3B 0 1meg
RK3B K3B 0 1500
* V3A plate -> V3B grid runs through the Treble pot network (not modelled);
* V3B's own grid leak (RG3B, above) stands in for its DC return.

* --- V4 (7025) — long-tailed-pair phase inverter. 82k (hot) / 100k (cold)
* 5% plates off the +410 V rail; both 1M grid leaks return to the tail
* junction JPI. Shared cathodes KPI sit 820 Ohm above JPI (both chart-read:
* +30 V / +28 V). Below JPI the drawing's own foot is fully lettered and is
* modelled from it: 6800 Ohm from JPI to the feedback node NFB, then 4700
* Ohm from NFB to ground, with the 56 kOhm speaker feedback returning to the
* same node (~0 V DC through the OT secondary, so it is a second path to
* ground and carries part of the tail current). The front panel's 25 kOhm-L
* PRESENCE pot bridges the 4700 Ohm end-to-end, its wiper going only to a
* 0.1 uF/200 V cap — a third DC path, omitted here as pots are omitted
* corpus-wide; including it would pull JPI from the 28.4 V below to ~27.8 V,
* both inside the chart's own +/-20%.
RL4A BP410 P4A 82k
XV4A P4A G4A KPI 12AX7
RG4A G4A JPI 1meg
RL4B BP410 P4B 100k
XV4B P4B G4B KPI 12AX7
RG4B G4B JPI 1meg
RTAIL KPI JPI 820
RT2   JPI NFB 6800
RPF   NFB 0 4700
RNFB  NFB 0 56k

* The mixing node. V3B's plate (+150 V) and the Normal channel's V2B plate
* (+190 V) each feed a 470k into MIX, and nothing else touches MIX at DC, so
* the pair is a 940k path between the two plates carrying about 40 uA —
* modelled, since that is a real DC current. MIX couples into V4A's grid
* through the .0005 uF cap (DC-open), onto a 1M leak already anchored at JPI.
RM2 P3B MIX 470k
RM1 P2B MIX 470k
C1 MIX G4A 0.0005u

* --- 5881 pair — fixed bias via 220k leaks from -54 V, cathodes grounded
* (no cathode resistor drawn). The plates hang on BP430 through the OT
* primary, whose DCR is omitted: that DCR is exactly what the drawing's
* printed "+428 V." at the plate leads is, 2 V under the +430 V it letters
* at the centre tap. The 470 Ohm 1W screen stoppers come off BP428 — node B,
* the choke's far end, the same node the dropper chain leaves from. Until
* 2026-09-15 this deck had the two the other way round (screens on +430,
* plates on +428), which ran the whole output current through the choke:
* the drawing's "+430 V." lead goes UP to the centre tap and its "+428 V."
* screen lead comes DOWN to node B. Two distinct single-ended bottles
* V5 / V6 — NOT dual-section "V5A/V5B", which the netlist parser would
* misread as one bottle's two triode halves.
RGL5 NBIAS G5 220k
XV5 BP430 S5 G5 0 5881
RS5 BP428 S5 470
RGL6 NBIAS G6 220k
XV6 BP430 S6 G6 0 5881
RS6 BP428 S6 470

* PI plate -> output grid couplers (0.1 uF on the drawing, DC-open). C2
* carries V4A (82k plate) to V5's grid, C3 carries V4B (100k plate) to V6's
* grid — modelled so the eventual layout-equivalence gate checks the
* inter-stage routing and push-pull phase natively.
C2 P4A G5 0.1u
C3 P4B G6 0.1u
