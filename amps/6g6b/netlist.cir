* 6G6-B (Blonde Bassman-style) — DC operating-point netlist
* Circuit Codex — CC-BY-SA 4.0. Independently drawn from the published 6G6-B
* (E-FB) drawing's component values (see meta.yaml); no drawing reproduced.
* The drawing labels all four preamp bottles 7025 — an alias for the 12AX7
* (reference/tubes/12ax7.yaml also_known_as) — so every small-signal stage
* uses the clean-room 12AX7 model.
*
* DC conventions — RAILS. The E-FB drawing prints supply figures at the
* bottom of each channel's own B+ lane (+230 V under the Bass row, +355 V
* under the Normal row) and again at the phase inverter (+410 V) and the
* output pair (+430 V screens, +428 V plates). Each is driven here as its
* OWN ideal source rather than derived through the drawn dropper chain
* (+430 -> choke -> +428 = node B -> 4.7k -> +410 -> 27k -> +355 = node C,
* with a 56k/1W from node B to the +230 Bass-row rail): an honest
* simplification flagged here rather than a solved chain.
* BP428 (5881 plates, OT primary DCR omitted), BP430 (5881 screens),
* BP410 (phase-inverter plate supply), BP355 (Normal-channel B+ lane, feeding
* BOTH that channel's plate loads), BP230 (Bass-row B+ lane, feeding V1A's
* plate load, V1B's plate direct, and both driver-bottle plate loads).
*
* The +230 V figure is a RAIL here and a PLATE VOLTAGE in the Normal channel:
* the drawing letters "+230 V." twice on the Bass row's own supply lane, and
* once more on the Normal channel at V2A's plate node — whose 100k load
* climbs to the +355 V lane, not to any +230 V rail. Reading that third
* "+230 V." as a shared preamp rail is what made an earlier pass hang V2A's
* plate load on +230 V and miss the printed cathode by a third.
*
* Two full channels (Bass, Normal) mix at the grid of a shared two-stage
* driver bottle, which drives a long-tailed-pair phase inverter and a
* fixed-bias 5881 pair. Each channel's Bass/Treble/Volume network is an
* abstracted control island (NOT modelled — same convention as every other
* amp in the corpus), as is the Bass channel's own Treble control, which
* physically sits between the driver bottle's two sections rather than
* beside its other two pots. Grid-leak resistors below stand in for
* "returns to ~0 V DC through the volume pot / mixing network above it" —
* since these stages draw no grid current, the exact leak value does not
* move the tube's own operating point (set by its cathode resistor and rail).
.include models/12ax7.inc
.include models/5881.inc

VBP428 BP428 0 DC 428
VBP430 BP430 0 DC 430
VBP410 BP410 0 DC 410
VBP355 BP355 0 DC 355
VBP230 BP230 0 DC 230
VBIAS  NBIAS 0 DC -54

* --- V1 (7025 = 12AX7) — BASS channel
* V1A input: 220k plate load off the Bass row's +230 V lane, 2700 Ohm
* cathode (bypassed on the drawing; DC-irrelevant). Grid returns to ground
* through the two 68 kOhm jack stoppers' 1 MOhm leak (jack parts, BOM only).
RL1A BP230 P1A 220k
XV1A P1A G1A K1A 12AX7
RG1A G1A 0 1meg
RK1A K1A 0 2700

* V1B — CATHODE FOLLOWER, exactly as the sheet draws it: the plate lead runs
* straight down to the +230 V lane with NO plate-load resistor in it, the
* grid takes V1A's plate DIRECTLY (no coupling cap, no grid leak drawn), and
* the 100 kOhm cathode load to ground is the stage's output, feeding the Bass
* channel's Bass/Volume network. The chart's +136 V here is that cathode:
* a follower riding ~1 V above the +135 V plate it is tied to, passing
* 1.36 mA through the 100 kOhm. (An earlier pass read the label as "+13.6 V"
* — the mark between the 3 and the 6 is the +230 V lane's own wire crossing
* the lettering — and modelled a common-cathode stage with an invented
* coupling cap, grid leak and 220k plate load. None of those three parts is
* on the sheet.)
XV1B BP230 P1A K1B 12AX7
RK1B K1B 0 100k

* --- V2 (7025) — NORMAL channel
* V2A input: 1500 Ohm cathode, 100k plate load climbing to the +355 V lane;
* its plate node is the chart's third "+230 V." reading, and the 125 V across
* that 100k is the 1.25 mA the printed 1.9 V over 1500 Ohm also implies.
RL2A BP355 P2A 100k
XV2A P2A G2A K2A 12AX7
RG2A G2A 0 1meg
RK2A K2A 0 1500

* V2B recovery: 2700 Ohm cathode, 220k plate load off the same +355 V lane.
RL2B BP355 P2B 220k
XV2B P2B G2B K2B 12AX7
RG2B G2B 0 1meg
RK2B K2B 0 2700

* --- V3 (7025) — shared driver + Bass-channel Treble recovery. Both
* channels' Volume outputs mix at V3A's grid (network not modelled, see
* header); the Bass channel's own Treble control (250k-A) sits between
* V3A's plate and V3B's grid. Both sections read +150 V on the chart off
* their own 100k/+230 V legs, and both cathodes are chart-read: 1500 Ohm at
* +1.2 V (V3A, bypassed) and 1500 Ohm at +1.3 V (V3B).
RL3A BP230 P3A 100k
XV3A P3A G3A K3A 12AX7
RG3A G3A 0 1meg
RK3A K3A 0 1500

RL3B BP230 P3B 100k
XV3B P3B G3B K3B 12AX7
RG3B G3B 0 1meg
RK3B K3B 0 1500
* V3A plate -> V3B grid runs through the Treble pot network (not modelled);
* V3B's own grid leak (RG3B, above) stands in for its DC return.

* --- V4 (7025) — long-tailed-pair phase inverter. 82k (hot) / 100k (cold)
* 5% plates off the +410 V rail; both 1M grid leaks return to the tail
* junction JPI. Shared cathodes KPI sit 820 Ohm above JPI (both chart-read:
* +30 V / +28 V). Below JPI the drawing's own foot is fully lettered and is
* modelled from it: 6800 Ohm from JPI to the feedback node NFB, then 4700
* Ohm from NFB to ground, with the 56 kOhm speaker feedback returning to the
* same node (~0 V DC through the OT secondary, so it is a second path to
* ground and carries part of the tail current). The front panel's 25 kOhm-L
* PRESENCE pot bridges the 4700 Ohm end-to-end, its wiper going only to a
* 0.1 uF/200 V cap — a third DC path, omitted here as pots are omitted
* corpus-wide; including it would pull JPI from the 28.4 V below to ~27.8 V,
* both inside the chart's own +/-20%.
RL4A BP410 P4A 82k
XV4A P4A G4A KPI 12AX7
RG4A G4A JPI 1meg
RL4B BP410 P4B 100k
XV4B P4B G4B KPI 12AX7
RG4B G4B JPI 1meg
RTAIL KPI JPI 820
RT2   JPI NFB 6800
RPF   NFB 0 4700
RNFB  NFB 0 56k

* V3B plate -> V4A grid coupling (the .0005 uF cap the chart shows landing
* on a 1M leak already anchored at JPI — DC-open, moves no operating point).
C1 P3B G4A 0.0005u

* --- 5881 pair — fixed bias via 220k leaks from -54 V, cathodes grounded
* (no cathode resistor drawn), 470 Ohm 1W screen resistors off +430 V, plates
* direct on +428 V (OT primary DCR omitted, matching the 2 V drawing split
* between the +430 V screen tap and the +428 V plate tap). Two distinct
* single-ended bottles V5 / V6 — NOT dual-section "V5A/V5B", which the
* netlist parser would misread as one bottle's two triode halves.
RGL5 NBIAS G5 220k
XV5 BP428 S5 G5 0 5881
RS5 BP430 S5 470
RGL6 NBIAS G6 220k
XV6 BP428 S6 G6 0 5881
RS6 BP430 S6 470

* PI plate -> output grid couplers (0.1 uF on the drawing, DC-open). C2
* carries V4A (82k plate) to V5's grid, C3 carries V4B (100k plate) to V6's
* grid — modelled so the eventual layout-equivalence gate checks the
* inter-stage routing and push-pull phase natively.
C2 P4A G5 0.1u
C3 P4B G6 0.1u
