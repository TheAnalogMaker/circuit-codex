* JTM45 (Marshall — 5F6-A-derived) — DC operating-point netlist
* Circuit Codex — CC-BY-SA 4.0. Independently drawn from the published JTM45
* factory drawing's component values and printed valve-voltage chart (see
* meta.yaml); no drawing reproduced.
*
* DC conventions: B+1 driven at the chart's +450 V reservoir (GZ34 cathode);
* downstream rails DERIVED through the real dropper values. The 20H choke is
* modeled as a DCR estimate; the output-transformer primary DCR is omitted, so
* the KT66 plate node sits at B+1 (chart prints 430 at the plate pin, 20 V of
* omitted OT/reservoir drop — within the 20% tube-pin tolerance). DC-open caps
* are MODELLED where both leads land on a named DC node (the PI->output couplers
* C9/C10, the tail-bootstrap C8, and the shared-input cathode-bypass C3) so their
* board placement is layout-checked; open at DC, they move no operating point.
* Tone-stack caps (a lead inside the abstracted tone network) stay omitted; the
* tone stack is fully capacitor-coupled at DC. The fixed-bias network (HT-tap
* diode, 150k, filter caps and
* grid-leaks) is replaced by an ideal -50 V source: the drawing prints no bias
* figure or idle current, so this is a representative estimate. Grid-stopper and
* grid-leak resistors carry no DC and are omitted (grids sit at their leak
* return). The tremolo section (V2 + transistor) is not part of this head.
.include models/12ax7.inc
.include models/kt66.inc

VBP1 BP1 0 DC 450
VBIAS NBIAS 0 DC -50

* rail chain: reservoir -> 20H choke -> screens node -> 8.2k -> PI -> 10k -> preamp
RCHOKE BP1 BP2 150
RD1 BP2 BP3 8.2k
RD2 BP3 BP4 10k

* V1 ECC83 — bright + normal input stages, shared 820R cathode (250uF bypass)
RL1 BP4 P1A 100k
XV1A P1A G1A KA 12AX7
RG1 G1A 0 1meg
RL2 BP4 P1B 100k
XV1B P1B G1B KA 12AX7
RG2 G1B 0 1meg
RK1 KA 0 820

* V3A ECC83 second stage (grid returns through vol pots + 270k mixers at DC)
RL3 BP4 P3A 100k
XV3A P3A G3A K3A 12AX7
RG3 G3A 0 1meg
* V3A cathode bias resistor — designator RK2 to match the board part, BOM, and
* schematic (all name this RK2; a lone RK3 here would break the layout-net check).
RK2 K3A 0 820

* V3B ECC83 cathode follower — grid DC-coupled to V3A plate, plate to preamp
* rail, 100k cathode load
XV3B BP4 P3A KCF 12AX7
RKCF KCF 0 100k

* V4 ECC83 long-tailed-pair phase inverter (82k/100k plates, 470R + 10k tail,
* both 1M grid leaks returned to the tail junction)
RLA BP3 PPIA 82k
XV4A PPIA GPIA KPI 12AX7
RGA GPIA JPI 1meg
RLB BP3 PPIB 100k
XV4B PPIB GPIB KPI 12AX7
RGB GPIB JPI 1meg
* C8: V4B grid AC-grounded to the tail junction (0.1u, DC-open). Both ends are
* real netlist nodes (GPIB == JPI at DC through RGB), so modelling it lets the
* gate check the cap actually lands on the tail junction, not elsewhere.
C8 GPIB JPI 0.1u
RTAIL KPI JPI 470
RT2 JPI 0 10k
* 27k negative-feedback resistor and 5k presence pot join the tail foot at
* ~0 V DC (speaker/pot returns) — DC-neutral, omitted here.

* KT66 pair — fixed bias via 220k grid leaks (RGL1/RGL2) from the -50 V line,
* 1k 2W screen resistors, cathodes grounded. Plates sit at B+1 (OT primary DCR
* omitted). The PI plates couple to the grids through 0.1u caps (C9/C10) + 33k
* grid stoppers (R5s/R6s): modelled so the layout-equivalence gate checks the
* inter-stage routing and push-pull phase natively (each output grid is its own
* node G5/G6, not the shared bias rail). Grid current is ~0, so each grid still
* sits at the -50 V bias node through its leak and the DC op point is unmoved.
C9 PPIA NG5 0.1u
R5s NG5 G5 33k
RGL1 G5 NBIAS 220k
XV5 BP1 S5 G5 0 KT66
RS1 BP2 S5 1k
C10 PPIB NG6 0.1u
R6s NG6 G6 33k
RGL2 G6 NBIAS 220k
XV6 BP1 S6 G6 0 KT66
RS2 BP2 S6 1k

* cathode-bypass cap (both leads on a named DC node — placement layout-checked)
C3 KA 0 250u
