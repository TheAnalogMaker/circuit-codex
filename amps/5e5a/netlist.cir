* 5E5-A (Tweed Pro-style) — DC operating-point netlist
* Circuit Codex — CC-BY-SA 4.0. Independently drawn from the published 5E5-A
* (J-EE) drawing's component values (see meta.yaml); no drawing reproduced.
*
* DC conventions: BP1 driven at the printed +390 V (the rectifier output and
* power-tube plate node, ahead of the choke); downstream nodes DERIVED. Choke
* DCR estimated at 110 R (the drawing prints +390 -> +385 V across it). OT
* primary DCR omitted. Bias supply replaced by an ideal -32 V source (its
* 10k / selenium / 100 uF / 56k network is a rectifier and filter, not an
* operating point this netlist can solve). DC-open caps are MODELLED where both
* leads land on a named DC node (the couplers and the cathode-bypass cans): open
* at DC they move no operating point, but they fix the inter-stage routing in
* the data. Caps with a lead inside a control network (the Treble branch, the
* Bass leg, the bright cap, the Presence cap) and the filter cans stay out.
* Heaters and the pilot lamp are not modelled.
*
* Stage chain, as the J-EE sheet draws it. V1 (12AY7) is the two-channel front
* end, one triode per channel on a shared 820 R cathode — the sheet's two input
* jacks per channel collapse to one representative grid path each. Both
* channels mix through their 1M volume pots and 270k resistors into V2 (12AY7),
* whose two sections are BOTH used: V2A a cathode-biased gain stage, DC-coupled
* into V2B, a cathode follower. The follower's cathode drives the tone network,
* the split treble/bass circuit the 5F4 also draws. V3 (12AX7) is a driver stage
* into a split-load (cathodyne) phase inverter, then a fixed-bias 6L6GB pair.
* Sections are lettered in signal order: A is the earlier stage in each bottle.
.include models/12ay7.inc
.include models/12ax7.inc
.include models/5881.inc

VBP1 BP1 0 DC 390
VBIAS NBIAS 0 DC -32

* rail: choke (DCR estimate) -> screens, then the two printed 10k droppers
RCHOKE BP1 BP2 110
RD1 BP2 BP3 10k
RD2 BP3 BP4 10k

* V1 12AY7 — instrument + mic channels, shared 820R cathode (the 25+25 uF can
* is modelled at the foot of this file; open at DC, it moves no operating point)
RL1 BP4 PAY1 100k
XV1A PAY1 GAY1 KAY 12AY7
RG1 GAY1 0 1meg
RL2 BP4 PAY2 100k
XV1B PAY2 GAY2 KAY 12AY7
RG2 GAY2 0 1meg
RK1 KAY 0 820

* V2A 12AY7 gain stage. Its grid is the mixing node, and the DC reference the
* sheet gives it is RF1, a 5 MEG returned to the tone network's bass-branch
* node, which RSH holds at 0 V. The 270k mixers also reach ground through the
* volume pots' tracks; with no grid current that parallel path moves nothing,
* and the pots are controls, so it is left out.
RL3 BP4 P2A 100k
XV2A P2A G2A K2A 12AY7
RK2 K2A 0 1.5k
C4b K2A 0 25u

* V2B 12AY7 cathode follower — grid DC-coupled to V2A's plate, plate straight
* on BP4, 100k cathode load. Its cathode is the tone network's source.
XV2B BP4 P2A KCF 12AY7
RKCF KCF 0 100k

* Tone network, bass branch — the resistive half, and the driver grid's DC path:
* 0.1 uF coupler -> TB (220k to ground; the 5 MEG return from V2A's grid lands
* here) -> 100k -> TW, the Bass pot's wiper -> 220k -> the driver grid. The Bass
* pot itself (one end grounded, the other through 0.005 uF) and the Treble branch
* (250 pF from the follower's cathode to the Treble pot, 0.01 uF from its cold
* end to ground, wiper on the driver grid) are controls or capacitor-isolated
* and stay out: at DC they only parallel resistances that carry no current.
C14 KCF TB 0.1u
RSH TB 0 220k
RF1 G2A TB 5meg
RSL TB TW 100k
RSR TW G3A 220k

* V3A 12AX7 driver, its grid on the tone network's output. The 100k negative
* feedback from the speaker and the 5k Presence rheostat (wiper to ground
* through 0.1 uF) land on this CATHODE, as the sheet draws them. At DC the 100k
* parallels RK3 through the output secondary and moves K3A by -0.8% (simulated
* with it in place). Annotation, not modelled.
RL4 BP3 P3A 100k
XV3A P3A G3A K3A 12AX7
RK3 K3A 0 1.5k

* V3B split-load cathodyne, driven from V3A's plate
C1 P3A GPI 0.02u
RL5 BP3 PPI 56k
XV3B PPI GPI KPI 12AX7
RKA KPI JPI 1.5k
RKB JPI 0 56k
RGPI GPI JPI 1meg

* 6L6GB pair — fixed-biased via 220k leaks from the -32 V supply; screens
* tied straight to BP2 (the sheet draws no screen resistors)
RGL1 NBIAS G61 220k
XV4 BP1 BP2 G61 0 5881
RGL2 NBIAS G62 220k
XV5 BP1 BP2 G62 0 5881
* cathodyne -> output-grid drive: 0.1u couplers (DC-open) + 1.5k stoppers,
* one from the PLATE, one from the CATHODE — the split-load pair of outputs
C2 PPI NG61 0.1u
R5s NG61 G61 1.5k
C3 KPI NG62 0.1u
R6s NG62 G62 1.5k

* V1's cathode-bypass can (both leads on a named DC node)
C4 KAY 0 25u
