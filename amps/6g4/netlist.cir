* 6G4 (Brown Super-style) — DC operating-point netlist
* Circuit Codex — CC-BY-SA 4.0. Independently drawn from the published 6G4
* (A-FJ) drawing's component values (see meta.yaml); no drawing reproduced.
* The drawing labels all five small bottles 7025 — an alias for the 12AX7
* (reference/tubes/12ax7.yaml also_known_as). The output pair is drawn
* "6L6GC" and simulated on the 6L6GC's own CC0 model, models/6l6gc.inc
* (reference/tubes/6l6gc.yaml) — no stand-in.
*
* The bottles, as the layout page's socket row places them (pin voltages
* printed at each socket): V1 carries BOTH channels' first stages, their
* cathodes joined on one 820 Ohm / 25 uF pair; V2 carries both channels'
* second stages on a second shared 820 Ohm / 25 uF pair; V3 is the vibrato's
* low-frequency oscillator (pins 1-3) and its phase splitter (pins 6-8); V4 is
* the harmonic-vibrato pair, both sections, cathodes joined; V5 is the
* long-tailed-pair phase inverter. Ten triode sections, all drawn. The same
* A-FJ arrangement as the brown Pro (amps/6g5), part for part in the preamp,
* vibrato and inverter; the 6G4 differs in its GZ34 rectifier and its 10K
* feedback resistor.
*
* Until 2026-09-10 this netlist modelled one bottle per channel stage, a
* "bias-vary" tremolo injecting into the -55 V line, and no vibrato pair; the
* channel cathode resistors it carried (1.5k) belong to the vibrato splitter,
* and the "mixing resistors" (6.8k, 220k) are channel 1's plate-load
* decoupler and channel 2's plate load.
*
* DC conventions. BP1 is DRIVEN at the +456 V the drawing prints at the 6L6GC
* plates. The drawing prints +458 V after the choke, where the screens and
* every dropper hang; with the choke's and the output transformer's winding
* resistance omitted, as throughout this corpus, the two collapse onto one
* node. The GZ34 and its reservoir are not modelled. The fixed-bias supply
* (a bias-tap rectifier, 8 uF, 10k, then 8 uF with a 56k bleeder) is
* replaced by an ideal -55 V source, printed directly on the drawing.
*
* Every other rail is DERIVED through a dropper the drawing letters, and the
* layout page prints the voltage at each one:
*   BP1 -> 4700 1W -> BC  (+430 V: the phase inverter's two plate loads)
*   BC  -> 56K 1W  -> BA  (+260 V: all four channel plate loads)
*   BP1 -> 56K 1W  -> BV  (+350 V: the vibrato pair's plate loads)
*   BV  -> 56K 1W  -> BL  (+275 V: the oscillator's and splitter's loads)
* The screens take no dropper: each hangs off BP1 through its own 470 Ohm-1W
* stopper.
*
* The two channels' second stages are loaded differently, and that is what the
* chart's +160 V / +120 V pair records. Channel 1's plate returns to rail A
* through 100K and then a 6800 decoupling resistor, and its output is taken at
* the junction of the two; channel 2's plate load is a single 220K.
*
* Harmonic vibrato. Channel 1's output is split into a low-pass branch (470K
* into a .005 to ground, then .01 to one grid of V4) and a high-pass branch
* (220K/220K divider, then 250 pF to V4's other grid). The two sections share
* a 4700 Ohm / 2 uF cathode pair, each has a 100K plate load off BV, and
* their plates recombine through 470K apiece at the node that also takes
* channel 2 (.05 + 1M) and feeds the phase inverter through .001. The
* low-frequency oscillator's output reaches one vibrato grid directly and the
* other through the splitter, so the two bands swell in turn. Both vibrato
* grids return through 1M each to the splitter's grid, which has a 1M leak to
* ground.
*
* MODELLED — V4, the vibrato pair: it is in the audio path and the chart prints
* its static point (+320 V plates, +3.3 V cathodes). MODELLED — V3B, the
* phase splitter: an ordinary grid-leak-returned, cathode-biased stage with a
* printed static point (+180 V plate, +1.5 V cathode), so there is nothing to
* exclude it for. EXCLUDED — V3A, the oscillator: a running phase-shift
* oscillator has no static DC point, the same reasoning amps/ab763 documents
* for its own. Its 470K plate load is excluded with it, so the current it
* draws while running (about 0.3 mA, on its printed +130 V plate) is missing
* from the BL and BV rails, which therefore simulate high; voltages.yaml says
* by how much. Its printed pins (+130 V plate, +1.3 V cathode) are reported
* for the record only.
*
* The tail foot. The phase inverter's 6800 tail lands on a foot node carrying
* a 1500 resistor to ground, the 10K negative-feedback resistor from the
* output transformer's secondary, the .1-200 cap that grounds the cold grid
* for signal, and the Presence branch (5K-L rheostat in series with a .1, so
* AC-only). The 1500 and the feedback resistor are both DC paths and are
* modelled as real resistors, the secondary's own resistance folded into
* ground. The Presence branch is omitted: its capacitor blocks DC.
*
* DC-open capacitors are MODELLED wherever both leads land on a named DC node
* (every cathode bypass, the couplers into and out of the vibrato pair and the
* phase inverter, the splitter's plate and grid caps, the output couplers) so
* the drawings' placement of them is checked; open at DC they move no
* operating point. Omitted: the tone stacks, the volume pots (each reaches the
* netlist only as the 1M leak standing for the grid below it, RG1D and RG2D),
* the oscillator's ladder and its Speed and Intensity controls, and the
* Presence branch. No netlist here models a tone-stack network.
.include models/12ax7.inc
.include models/6l6gc.inc

VBP1 BP1 0 DC 456
VBIAS NBIAS 0 DC -55

* --- Dropper chain (all four read from the drawing) ---
RD1 BP1 BC 4.7k
RD2 BC BA 56k
RD3 BP1 BV 56k
RD4 BV BL 56k

* --- V1: both channels' first stages, one shared cathode pair ---
RL1I BA P1I 100k
XV1A P1I G1I KI 12AX7
RG1I G1I 0 1meg
RL2I BA P2I 100k
XV1B P2I G2I KI 12AX7
RG2I G2I 0 1meg
RKI KI 0 820
CKI KI 0 25u

* --- V2: both channels' second stages, one shared cathode pair ---
* Channel 1: 100K plate load, then 6800 to rail A; output at their junction.
RL1D N1D P1D 100k
RLD1 BA N1D 6.8k
XV2A P1D G1D KD 12AX7
RG1D G1D 0 1meg
* Channel 2: 220K plate load.
RL2D BA P2D 220k
XV2B P2D G2D KD 12AX7
RG2D G2D 0 1meg
RKD KD 0 820
CKD KD 0 25u

* --- Harmonic vibrato: band-splitting filters off channel 1 ---
CC1D N1D VIN 0.05u
RLP VIN VLP 470k
CLP VLP 0 0.005u
CV1 VLP GV1 0.01u
RHP1 VIN VHP 220k
RHP2 VHP 0 220k
CV2 VHP GV2 250p

* --- V4: the vibrato pair ---
RLV1 BV PV1 100k
XV4A PV1 GV1 KV 12AX7
RLV2 BV PV2 100k
XV4B PV2 GV2 KV 12AX7
RKV KV 0 4.7k
CKV KV 0 2u
RGV1 GV1 GS 1meg
RGV2 GV2 GS 1meg
RMV1 PV1 VMIX 470k
RMV2 PV2 VMIX 470k

* --- V3B: the oscillator's phase splitter (V3A, the oscillator, excluded) ---
RLS BL PS 100k
XV3B PS GS KS 12AX7
RKS KS 0 1.5k
CKS KS 0 25u
RGS GS 0 1meg
CGS GS 0 0.05u
CFS PS GS 0.001u
CPS PS 0 0.25u
CSV PS XSV 0.05u
RSV XSV GV2 1meg

* --- Channel 2 into the mixing node ---
CC2D P2D X2M 0.05u
RM2 X2M VMIX 1meg

* --- V5: long-tailed-pair phase inverter, off BC ---
CPIN VMIX GPIA 0.001u
RLPA BC PPIA 82k
XV5A PPIA GPIA KPI 12AX7
RGPA GPIA JPI 1meg
RLPB BC PPIB 100k
XV5B PPIB GPIB KPI 12AX7
RGPB GPIB JPI 1meg
RTAIL KPI JPI 820
RT2 JPI NFT 6800
RPF NFT 0 1500
RNFB NFT 0 10k
CGB GPIB NFT 0.1u
CPP PPIA PPIB 47p

* PI-plate -> 6L6GC-grid coupling caps (0.05uF, DC-open).
C1 PPIA G61 0.05u
C2 PPIB G62 0.05u

* --- Output pair 6L6GC (fixed bias): grids to -55 V through 220k-5% leaks,
*     screens off BP1 through 470 Ohm-1W stoppers each, cathodes grounded,
*     plates at BP1 (OT primary DCR omitted).
RGL1 NBIAS G61 220k
RS1 BP1 BS1 470
XV7 BP1 BS1 G61 0 6L6GC
RGL2 NBIAS G62 220k
RS2 BP1 BS2 470
XV8 BP1 BS2 G62 0 6L6GC
