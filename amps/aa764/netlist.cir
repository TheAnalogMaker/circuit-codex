* AA764 (Blackface Champ-style) — DC operating-point netlist
* Circuit Codex — CC-BY-SA 4.0. Independently drawn from published circuit
* facts (see meta.yaml sources); no factory drawing reproduced.
*
* DC conventions (v0, documented in notes.md):
*  - B+1 = 360 V per the published chart (the reservoir node, read from the
*    drawing). Every node below it is DERIVED by simulation, never asserted.
*  - Output transformer primary DCR omitted, so the 6V6 plate IS node BP1.
*    The chart prints +360 V at the reservoir and +350 V at the plate; that
*    10 V difference is the 125A35A primary winding resistance, which the
*    drawing does not print. It is therefore not modelled and the plate is not
*    gated as a separate node (see voltages.yaml).
*  - The screen hangs off BP2 (the middle 20 uF node) with no screen stopper —
*    the drawing shows the screen wired straight to that node.
*  - Volume / treble / bass controls are AC-only networks behind blocking caps;
*    they carry no DC and are abstracted. V1B's grid returns to ground through
*    the 1 Meg volume pot, which IS modelled as the grid's DC return.
*  - DC-open caps (coupling / cathode-bypass) are MODELLED where both leads
*    land on a named DC node, so their board placement is machine-checked by
*    verify_layout_nets; they are open at DC and move no operating point.
*    Tone-stack caps, whose far leads sit inside the abstracted pot network,
*    stay out.
*  - Negative feedback: the speaker jack sits at DC ground through the output
*    transformer secondary's near-zero DCR, so the 2.7k feedback resistor is
*    modelled as 2.7k from the cathode divider node KFB to ground, in parallel
*    with the 47 Ohm leg.
.include models/12ax7.inc
.include models/6v6gt.inc

VBP1 BP1 0 DC 360

* power rail droppers: BP1 (reservoir / OT primary) -> BP2 (screen)
* -> BP3 (preamp plates)
R14 BP1 BP2 1k
R15 BP2 BP3 10k

* V1A input stage (grid returned to ground through the input jacks' 1M leak)
R4  BP3 P1A 100k
XV1A P1A G1A K1A 12AX7
R3  G1A 0 1meg
R5  K1A 0 1500

* V1B driver stage. Cathode sits above the feedback divider: 1.5k (bypassed)
* down to KFB, then 47 Ohm to ground; the 2.7k feedback leg lands on KFB.
R8  BP3 P1B 100k
XV1B P1B G1B K1B 12AX7
RVOL G1B 0 1meg
R9  K1B KFB 1500
R10 KFB 0 47
R11 KFB 0 2700

* 6V6GT output stage (plate at BP1 through the OT primary, screen at BP2)
XV2 BP1 BP2 G2 K2 6V6GT
R12 G2 0 220k
R13 K2 0 470

* DC-open caps (both leads on a named DC node — placement layout-checked)
C1  K1A 0   25u
C5  K1B KFB 25u
C7  K2  0   25u
C6  P1B G2  0.02u
