* 6G5 (Brown Pro-style) — DC operating-point netlist
* Circuit Codex — CC-BY-SA 4.0. Independently drawn from the published Fender
* "Pro-Amp" Model 6G5 drawing's component values (see meta.yaml); no drawing
* reproduced. The drawing labels all five small bottles 7025 — an alias for the
* 12AX7 (reference/tubes/12ax7.yaml also_known_as). The output tubes are
* printed 6L6GC and are simulated on the 6L6GC's own clean-room model,
* models/6l6gc.inc (reference/tubes/6l6gc.yaml), which carries that tube's
* 30 W / 500 V design-maximum ratings — the ones the load-line explorer
* overlays on this circuit's +456 V plate rail.
*
* The bottles, as the layout page's socket row places them (pin voltages
* printed at each socket): V1 carries BOTH channels' first stages, their
* cathodes joined on one 820 Ohm / 25 uF pair; V2 carries both channels'
* second stages on a second shared 820 Ohm / 25 uF pair; V3 is the vibrato's
* low-frequency oscillator (pins 1-3) and its phase splitter (pins 6-8); V4 is
* the harmonic-vibrato pair, both sections, cathodes joined; V5 is the
* long-tailed-pair phase inverter. Ten triode sections, all drawn.
*
* DC conventions. BP1 is DRIVEN at the +456 V the drawing prints at the 6L6GC
* plates. The drawing prints +460 V at the reservoir end of the choke and
* +458 V after it, where the screens and every dropper hang; with the choke's
* and the output transformer's winding resistance omitted, as throughout this
* corpus, those three collapse onto one node. The silicon rectifier and its
* reservoir are not modelled, exactly as a tube rectifier's own drop is not
* modelled elsewhere. The bias supply is replaced by an ideal -55 V source:
* all 29 fixed-bias circuits documented here drive their bias supply from an
* ideal source instead of modelling the rectifier, 28 at the bias line itself
* and the 5G9 one node upstream, at the rectifier output.
*
* Every other rail is DERIVED through a dropper the drawing letters, and the
* layout page prints the voltage at each one:
*   BP1 -> 4700 1W -> BC  (+430 V: the phase inverter's two plate loads)
*   BC  -> 56K 1W  -> BA  (+260 V: all four channel plate loads)
*   BP1 -> 56K 1W  -> BV  (+350 V: the vibrato pair's plate loads)
*   BV  -> 56K 1W  -> BL  (+275 V: the oscillator's and splitter's loads)
* The screens take no dropper: each hangs off BP1 through its own 470 Ohm-1W
* stopper.
*
* The two channels' second stages are loaded differently, and that is what the
* chart's +160 V / +120 V pair records. Channel 1's plate returns to rail A
* through 100K and then a 6800 decoupling resistor, and its output is taken at
* the junction of the two; channel 2's plate load is a single 220K.
*
* Harmonic vibrato. Channel 1's output is split into a low-pass branch (470K
* into a .005 to ground, then .01 to one grid of V4) and a high-pass branch
* (220K/220K divider, then 250 pF to V4's other grid). The two sections share
* a 4700 Ohm / 2 uF cathode pair, each has a 100K plate load off BV, and
* their plates recombine through 470K apiece at the node that also takes
* channel 2 (.05 + 1M) and feeds the phase inverter through .001. The
* low-frequency oscillator's output reaches one vibrato grid directly and the
* other through the splitter, so the two bands swell in turn. Both vibrato
* grids return through 1M each to the splitter's grid, which has a 1M leak to
* ground.
*
* MODELLED — V4, the vibrato pair: it is in the audio path and the chart prints
* its static point (+320 V plates, +3.3 V cathodes). MODELLED — V3B, the
* phase splitter: an ordinary grid-leak-returned, cathode-biased stage with a
* printed static point (+180 V plate, +1.5 V cathode), so there is nothing to
* exclude it for. EXCLUDED — V3A, the oscillator: a running phase-shift
* oscillator has no static DC point, the same reasoning amps/ab763 documents
* for its own. Its 470K plate load is excluded with it, so the current it
* draws while running (about 0.3 mA, on its printed +130 V plate) is missing
* from the BL and BV rails, which therefore simulate high; voltages.yaml says
* by how much. Its printed pins (+130 V plate, +1.3 V cathode) are reported
* for the record only.
*
* The tail foot. The phase inverter's 6800 tail lands on a foot node carrying
* a 1500 resistor to ground, the 22K negative-feedback resistor from the
* output transformer's secondary, the .1-200 cap that grounds the cold grid
* for signal, and the Presence branch (5K-L rheostat in series with a .1, so
* AC-only). The 1500 and the feedback resistor are both DC paths and are
* modelled as real resistors, the secondary's own resistance folded into
* ground. The Presence branch is omitted: its capacitor blocks DC.
*
* DC-open capacitors are MODELLED wherever both leads land on a named DC node
* (every cathode bypass, the couplers into and out of the vibrato pair and the
* phase inverter, the splitter's plate and grid caps, the output couplers) so
* the drawings' placement of them is checked; open at DC they move no
* operating point. Omitted: the tone stacks, the volume pots (each reaches the
* netlist only as the 1M leak standing for the grid below it, RG1B and RG2B),
* the oscillator's ladder and its Speed and Intensity controls, and the
* Presence branch. No netlist here models a tone-stack network.
.include models/12ax7.inc
.include models/6l6gc.inc

VBP1 BP1 0 DC 456
VBIAS NBIAS 0 DC -55

* --- Dropper chain (all four read from the drawing) ---
RD1 BP1 BC 4.7k
RD2 BC BA 56k
RD3 BP1 BV 56k
RD4 BV BL 56k

* --- V1: both channels' first stages, one shared cathode pair ---
RL1A BA P1A 100k
XV1A P1A G1A K1 12AX7
RG1A G1A 0 1meg
RL2A BA P2A 100k
XV1B P2A G2A K1 12AX7
RG2A G2A 0 1meg
RK1 K1 0 820
CK1 K1 0 25u

* --- V2: both channels' second stages, one shared cathode pair ---
* Channel 1: 100K plate load, then 6800 to rail A; output at their junction.
RL1B N1D P1B 100k
RLD1 BA N1D 6.8k
XV2A P1B G1B K2 12AX7
RG1B G1B 0 1meg
* Channel 2: 220K plate load.
RL2B BA P2B 220k
XV2B P2B G2B K2 12AX7
RG2B G2B 0 1meg
RK2 K2 0 820
CK2 K2 0 25u

* --- Harmonic vibrato: band-splitting filters off channel 1 ---
CC1D N1D VIN 0.05u
RLP VIN VLP 470k
CLP VLP 0 0.005u
CV1 VLP GV1 0.01u
RHP1 VIN VHP 220k
RHP2 VHP 0 220k
CV2 VHP GV2 250p

* --- V4: the vibrato pair ---
RLV1 BV PV1 100k
XV4A PV1 GV1 KV 12AX7
RLV2 BV PV2 100k
XV4B PV2 GV2 KV 12AX7
RKV KV 0 4.7k
CKV KV 0 2u
RGV1 GV1 GS 1meg
RGV2 GV2 GS 1meg
RMV1 PV1 VMIX 470k
RMV2 PV2 VMIX 470k

* --- V3B: the oscillator's phase splitter (V3A, the oscillator, excluded) ---
RLS BL PS 100k
XV3B PS GS KS 12AX7
RKS KS 0 1.5k
CKS KS 0 25u
RGS GS 0 1meg
CGS GS 0 0.05u
CFS PS GS 0.001u
CPS PS 0 0.25u
CSV PS XSV 0.05u
RSV XSV GV2 1meg

* --- Channel 2 into the mixing node ---
CC2D P2B X2M 0.05u
RM2 X2M VMIX 1meg

* --- V5: long-tailed-pair phase inverter, off BC ---
CPIN VMIX GPIA 0.001u
RLA BC PPIA 82k
XV5A PPIA GPIA KPI 12AX7
RGA GPIA JPI 1meg
RLB BC PPIB 100k
XV5B PPIB GPIB KPI 12AX7
RGB GPIB JPI 1meg
RTAIL KPI JPI 820
RT2 JPI NFT 6.8k
RPRES NFT 0 1.5k
RNFB NFT 0 22k
CGB GPIB NFT 0.1u
CPP PPIA PPIB 47p

* PI-plate -> output-grid coupling caps (0.05u printed, DC-open).
C1 PPIA G71 0.05u
C2 PPIB G72 0.05u

* --- Output stage: two 6L6GC, fixed bias, grounded cathodes ---
RGL1 NBIAS G71 220k
RSC1 BP1 S71 470
XV7 BP1 S71 G71 0 6L6GC
RGL2 NBIAS G72 220k
RSC2 BP1 S72 470
XV8 BP1 S72 G72 0 6L6GC
