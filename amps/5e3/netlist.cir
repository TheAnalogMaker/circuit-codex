* 5E3 (Tweed Deluxe-style) — DC operating-point netlist
* Circuit Codex — CC-BY-SA 4.0. Independently drawn from the published 5E3
* (F-EE) drawing's component values (see meta.yaml); no drawing reproduced.
*
* DC conventions: B+1 driven at Robinette's published 370 V measurement
* (the F-EE drawing carries no voltage chart); downstream nodes DERIVED.
* OT primary DCR omitted. DC-open caps (coupling / cathode-bypass) are modelled
* where both leads land on a named DC node (placement then layout-checked; open
* at DC, they move no operating point); caps into the abstracted volume/tone
* network stay omitted.
* Cathodyne PI per the drawing: cathode -> 1.5k -> junction -> 56k -> gnd,
* with the 1M grid leak returned to the junction; the grid is AC-coupled from
* the V2A plate by C3, which F-EE draws with an illegible value (".02 .1FD." on
* the layout, no value on the schematic). C3 is not modelled (DC-open; no value
* is invented for it).
.include models/12ay7.inc
.include models/12ax7.inc
.include models/6v6gt.inc

VBP1 BP1 0 DC 370

* rail droppers (5,000 ohm then 22k per the drawing; three 16 uF/450 V caps)
RD1 BP1 BP2 5k
RD2 BP2 BP3 22k

* V1 12AY7 — two channels, shared 820R cathode (25 uF bypass omitted for DC)
* RG1/RG2 hang from each channel's jack-1 tip; the 68k stoppers (two per grid,
* one per jack) carry no DC grid current, so the leak sits on the grid node.
RL1 BP3 PAY1 100k
XV1A PAY1 GAY1 KAY 12AY7
RG1 GAY1 0 1meg
RL2 BP3 PAY2 100k
XV1B PAY2 GAY2 KAY 12AY7
RG2 GAY2 0 1meg
RK1 KAY 0 820

* V2A 12AX7 second stage. F-EE feeds each 1M volume on its wiper and joins
* the pots' near ends into the V2A grid, the far ends grounded, so the grid's
* DC return is the two whole tracks in parallel whatever the knobs say. RG3
* stands in for that return as one lump; no grid current flows, so its value
* moves no node. (The tone pot's wiper also sits on G2A, capacitor-coupled at
* both ends; DC-open.)
RL3 BP3 P2A 100k
XV2A P2A G2A K2A 12AX7
RG3 G2A 0 1meg
RK2 K2A 0 1.5k

* V2B cathodyne phase inverter
RL4 BP3 PPI 56k
XV2B PPI GPI KPI 12AX7
RKA KPI JPI 1.5k
RKB JPI 0 56k
RGPI GPI JPI 1meg

* 6V6GT pair, shared 250R/5W cathode, 220k grid leaks (1.5k stoppers DC-nil)
XV3 BP1 BP2 G6A K66 6V6GT
RG6A G6A 0 220k
XV4 BP1 BP2 G6B K66 6V6GT
RG6B G6B 0 220k
RK66 K66 0 250

* DC-open caps (both leads on a named DC node — placement layout-checked):
* cathode-bypass caps + the cathodyne's two output couplers. The cathode-side
* coupler C8 is taken off the cathode itself (KPI), the top of the 1.5k — the
* F-EE schematic runs the .1-200 from the dot above the 1500, and the layout
* puts the cap's eyelet on the 1500's cathode end. The 1.5k/56k junction (JPI)
* carries only the grid-leak return.
C10 KAY 0 25u
C4  K2A 0 25u
C9  K66 0 25u
C7  PPI G6A 0.1u
C8  KPI G6B 0.1u
